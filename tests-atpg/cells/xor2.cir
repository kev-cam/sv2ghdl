* Behavioral XOR2 gate for ATPG stimulus demo
*
.subckt xor2 a b y vdd vss
Bout y vss V = {V(vdd,vss) * ABS(URAMP(V(a,vss)-0.9)/0.9 - URAMP(V(b,vss)-0.9)/0.9)}
.ends xor2
