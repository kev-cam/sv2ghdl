* device-level reference: 3-stage BJT common-emitter amplifier (bench.cir)
Vcc vcc 0 12
Vin in 0 SIN(0 0.01 10k)
Rc1 vcc c1 4.7k
Rb1 vcc b1 100k
Re1 e1 0 470
Cin in b1 1u
Q1 c1 b1 e1 QN
Ce1 e1 0 10u
Rc2 vcc c2 4.7k
Rb2 vcc b2 100k
Re2 e2 0 470
Cc1 c1 b2 1u
Q2 c2 b2 e2 QN
Ce2 e2 0 10u
Rc3 vcc c3 4.7k
Rb3 vcc b3 100k
Re3 e3 0 470
Cc2 c2 b3 1u
Q3 c3 b3 e3 QN
Ce3 e3 0 10u
Cout c3 out 1u
Rload out 0 10k
.model QN NPN(BF=200 IS=1e-14 VAF=100 RB=10 RC=1 RE=0.5 CJC=3p CJE=8p TF=0.4n TR=10n)
.tran 20n 2m 0 20n
.print tran format=gnuplot v(c1) v(c2) v(c3) v(out)
.end
