* bfit candidate -- 3x ce_stage macromodel. __param__ tokens are filled by the
* tuner. For the Xyce driver this uses the SPICE realisation of ce_stage.vams
* (B-source = the same clamped transfer); the ngspice/OpenVAF driver compiles the
* portable ce_stage.vams directly. Stimulus + probes must match the reference.
Vin in 0 SIN(0 0.01 10k)
Cin in n1 1u
X1 n1 c1 ce_stage
Cc1 c1 n2 1u
X2 n2 c2 ce_stage
Cc2 c2 n3 1u
X3 n3 c3 ce_stage
Cout c3 out 1u
Rload out 0 10k
.subckt ce_stage in out PARAMS: gain=__gain__ Vlo=__Vlo__ Vhi=__Vhi__ Rout=__Rout__ Rin=100k fp=__fp__
Rin in 0 {Rin}
* linear transconductance (stiff source) -> dominant pole (Rp=1, Cp -> fp) -> rail clip
Bvlin vlin 0 V={ (Vhi+Vlo)/2 - gain*V(in) }
Rp vlin pl 1
Cp pl 0 {1/(6.2832*fp)}
Bvc vc 0 V={ max(Vlo, min(Vhi, V(pl))) }
Rout vc out {Rout}
.ends
.tran 1u 2m
.print tran format=gnuplot v(c1) v(c2) v(c3) v(out)
.end
