// ce_stage.vams -- portable Verilog-AMS (Accellera LRM) behavioral macromodel
// for a common-emitter gain stage. Signal-flow only: 2 programmable resistors
// set the DC operating point/output impedance; an AC transconductance with a
// hard min/max rail clamp gives the large-signal voltage transfer (gain +
// clipping) -- no tanh (transcendentals are expensive per step).
// No device physics, no current/power balance -> cheap, and smooth so the
// integrator can take large adaptive timesteps. Runs on any VAMS engine
// (OpenVAF/ngspice, Spectre, AMS-Designer, Xyce/PyMS).
`include "disciplines.vams"

module ce_stage(in, out);
  inout in, out;
  electrical in, out;
  parameter real gain = 9.5    from (0:inf);   // large-signal stage gain
  parameter real Vlo  = 1.0;                    // bottom rail clamp
  parameter real Vhi  = 9.0;                    // top rail clamp
  parameter real Rout = 600    from (0:inf);    // output impedance
  parameter real Rin  = 100000 from (0:inf);    // input DC reference
  parameter real fp   = 6e3    from (0:inf);    // dominant pole (Hz): the in-band
                                                 // Miller roll-off the static model lacked
  electrical pl;                                 // internal pole node
  real ctr, vlin, cp;
  analog begin
    ctr = 0.5*(Vhi + Vlo);
    cp  = 1.0/(6.2832*fp);                       // with the 1-mho pull below -> pole at fp
    I(in)  <+ V(in) / Rin;                       // input bias
    vlin = ctr - gain * V(in);                   // linear transconductance (unclamped)
    I(pl)  <+ (V(pl) - vlin) + cp*ddt(V(pl));    // single dominant pole at fp
    I(out) <+ (V(out) - max(Vlo, min(Vhi, V(pl)))) / Rout;  // rail clip behind Rout
  end
endmodule
