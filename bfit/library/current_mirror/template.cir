* bfit current-mirror macromodel -- two-part I->V / V->I.
*
* I->V (reference, the diode-connected device's job): a voltage source vt off
*   the rail feeds a 1-ohm sense resistor, so the reference current develops an
*   overdrive VOLTAGE on the shared gate node `ref`. With the 1 ohm the drop is
*   numerically the current, normalized on the smallest device in the mirror.
* V->I (each output reads that node): I_out = ratio * overdrive, where
*   ratio = (W/L)_out / (W/L)_smallest, then GOING RESISTIVE near the rail --
*   a min/max clamp (no tanh) makes it ohmic in the last `vsat` of headroom and
*   saturate beyond, so the output current folds to zero at the supply and can
*   never run past it. ratio is passed per instance; vt, vsat are tuned.
*   (Superseded by the cmout Verilog-A legs emitted in recognize_mirror.)
*
* (test harness below is for the tuner: a 5T OTA single-ended stage)
Vdd vdd 0 3.3
Vcm cm 0 1.65
Vsig inp cm SIN(0 0.05 1meg)
Vbias gb 0 0.95
Mtail tail gb 0 0 NM W=20u L=0.5u
M1 d1 inp tail 0 NM W=10u L=0.5u
M2 out cm  tail 0 NM W=10u L=0.5u
Xmir vdd d1 out current_mirror ratio=1.0
Cl out 0 0.5p
.model NM NMOS (LEVEL=1 VTO=0.6 KP=150u LAMBDA=0.02)
.subckt current_mirror rail ref out PARAMS: vt=__vt__ vsat=__vsat__ ratio=1.0
* I -> V : reference current -> overdrive voltage across the 1-ohm sense
Vt rail vtn {vt}
R1 vtn ref 1
* V -> I : mirror current, straight function of overdrive x size, resistive near rail
Bout rail out I={ ratio*(V(rail)-V(ref)-vt) * max(-1, min(1, (V(rail)-V(out))/vsat)) }
.ends
.tran 5n 5u
.print tran format=gnuplot v(out) v(d1)
.end
