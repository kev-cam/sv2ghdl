* UG p.110 npn_mod binning by area
* generated by vamos
vin 1 0 DC 1.0
vb 2 0 DC 0.7
vb3 3 0 DC 0.65
.subckt npn_mod c b e s params: area=5e-12 vamos_mfactor=1.0
qnpn_mod c b e s npn20x20 m={vamos_mfactor}
.model npn20x20 npn level=1 is=3.77e-16 vaf=60.5
.ends npn_mod
.subckt npn_mod__vb1 c b e s params: area=5e-12 vamos_mfactor=1.0
qnpn_mod c b e s npn10x10 m={vamos_mfactor}
.model npn10x10 npn level=1 is=3.5e-16 vaf=61.5
.ends npn_mod__vb1
.subckt npn_mod__vb2 c b e s params: area=5e-12 vamos_mfactor=1.0
qnpn_mod c b e s npn_default m={vamos_mfactor}
.model npn_default npn level=1 is=3.2e-16 vaf=59.8
.ends npn_mod__vb2
xq1 1 2 0 0 npn_mod area=3.5e-10
xq2 1 3 0 0 npn_mod__vb1 area=2.5e-11
xq3 1 3 0 0 npn_mod__vb2 area=1e-09
.options device temp=25.0 tnom=25.0
.tran 1e-09 1e-08
.print tran format=raw file=vamos_tran.raw v(1) i(vin)
.end
