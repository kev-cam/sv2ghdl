* spectre model group
* generated by vamos
.model nch.2 nmos level=9 tox=4e-09 toxm=4e-09 u0=0.04 vth0=0.42 lmax=1e-06 wmax=0.0001 lmin=2e-07 wmin=1e-06 capmod=2.0
.model ref2 nmos level=9 vth0=0.42 tox=4e-09 toxm=4e-09 u0=0.04 capmod=2.0
vd d 0 DC 1.0
vg g 0 DC 1.0
vr r 0 DC 1.0
m1 d g 0 0 nch.2 w=2e-06 l=5e-07 nrd=0.0 nrs=0.0
mr r g 0 0 ref2 w=2e-06 l=5e-07 nrd=0.0 nrs=0.0
.options device temp=27.0 tnom=27.0
.tran 1e-10 1e-09
.print tran format=raw file=vamos_tran.raw v(*)
.end
