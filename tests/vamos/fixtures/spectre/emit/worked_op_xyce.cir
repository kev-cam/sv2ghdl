* RC Low-Pass Filter
* generated by vamos
.param rval=1000.0
V1 in 0 DC 0.0 AC 1.0 0.0 PULSE(0.0 1.0 0.001 1e-06 1e-06 0.004 0.01)
X1 in out rcsec r={rval}
.subckt rcsec a b params: r=1000.0 vamos_mfactor=1.0
R1 a b {r} m={vamos_mfactor}
C1 b 0 1e-06 m={vamos_mfactor}
.ends rcsec
.options device temp=27.0 tnom=27.0 gmin=1e-12
.OP
.PRINT DC FORMAT=RAW FILE=vamos_a1.raw V(*) I(V1)
.end
