* verilog-a letter device
* generated by vamos
.hdl "toy_resistor.va"
v1 a 0 DC 1.0
.model resistor__vamos r level=6
ry1 a b resistor__vamos R=3000.0
r2 b 0 1000.0
.options device temp=27.0 tnom=27.0
.tran 1e-10 1e-09
.print tran format=raw file=vamos_tran.raw v(b)
.end
