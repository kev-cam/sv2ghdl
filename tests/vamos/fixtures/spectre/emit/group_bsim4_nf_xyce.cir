* spectre bsim4 model group, nf > 1
* generated by vamos
.model nch.2 nmos level=54 vth0=0.45 lmin=1e-07 lmax=1e-05 wmin=1e-06 wmax=0.0001 toxe=4e-09 u0=0.04 rdsmod=1.0 igbmod=1.0
.model ref1 nmos level=54 vth0=0.3 toxe=4e-09 u0=0.04 rdsmod=1.0 igbmod=1.0
.model ref2 nmos level=54 vth0=0.45 toxe=4e-09 u0=0.04 rdsmod=1.0 igbmod=1.0
vd d 0 DC 1.0
vg g 0 DC 1.0
vr1 r1 0 DC 1.0
vr2 r2 0 DC 1.0
m1 d g 0 0 nch.2 w=2e-06 l=5e-07 nf=4.0 nrd=0.0 nrs=0.0
mr1 r1 g 0 0 ref1 w=2e-06 l=5e-07 nf=4.0 nrd=0.0 nrs=0.0
mr2 r2 g 0 0 ref2 w=2e-06 l=5e-07 nf=4.0 nrd=0.0 nrs=0.0
.options device temp=27.0 tnom=27.0
.tran 1e-10 1e-09
.print tran format=raw file=vamos_tran.raw v(*)
.end
