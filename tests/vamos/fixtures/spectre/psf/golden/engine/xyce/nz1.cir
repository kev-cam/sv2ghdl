* divider noise, one STEP
V1 in 0 DC 1 AC 1 0
R1 in out 1k
R2 out 0 1k
.STEP R2:R LIST 1k 2k
.NOISE V(out) V1 DEC 2 1 100
.PRINT NOISE FILE=nz1.prn ONOISE INOISE DNO(R1) DNO(R2)
.END
