// analysis parameters are expressions and enumerations (ref19 p.474, §3.11)
parameters p1=1u p2=2u
model nch bsim3v3 type=n vtho=0.4
tr1 tran stop=(p1+p2)*50 errpreset=conservative method=gear2 maxstep=10n write="%C:r.ic"
ac1 ac start=1 stop=1G dec=10 freq=1k prevoppoint=yes
noise1 (out 0) noise start=1 stop=1M dec=5 iprobe=V1 oprobe=R1
xf1 (out 0) xf start=1 stop=1M dec=5 probe=R1 stimuli=sources
dc1 dc dev=V1 param=dc start=0 stop=5 step=0.1 write="op.dc"
dc2 dc param=temp values=[-40 27 125]
dc3 dc mod=nch param=vth0 center=0.4 span=0.1 lin=10
