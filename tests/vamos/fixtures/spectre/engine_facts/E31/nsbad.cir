* nodeset with unknown node
V1 in 0 DC 1
R1 in out 1k
C1 out 0 1n
.NODESET V(nosuch)=0.2
.OP
.PRINT DC FORMAT=RAW FILE=nsbad.raw V(OUT)
.end
