* ic in a dc sweep
V1 in 0 DC 1
R1 in out 1k
R2 out 0 1k
C1 out 0 1u
.IC V(out)=0.2
.DC V1 0 2 1
.PRINT DC FORMAT=RAW FILE=icdc.raw V(OUT)
.end
