* ic in ac
V1 in 0 DC 1 AC 1
R1 in out 1k
R2 out 0 1k
C1 out 0 1u
D1 out 0 DM
.MODEL DM D IS=1e-14
.IC V(out)=0.2
.AC LIN 1 1 1
.PRINT AC FORMAT=RAW FILE=icac.raw VR(OUT) VI(OUT)
.end
