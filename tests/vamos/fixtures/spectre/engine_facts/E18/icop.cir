* ic in op and ac
V1 in 0 DC 1 AC 1
R1 in out 1k
R2 out 0 1k
C1 out 0 1u
.IC V(out)=0.2
.OP
.PRINT DC FORMAT=RAW FILE=icop.raw V(OUT) I(V1)
.end
