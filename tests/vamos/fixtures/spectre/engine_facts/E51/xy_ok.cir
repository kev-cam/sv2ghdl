* cpow print rule on Xyce, fmod, hypot absent
.param x0=0 y0=0 y2=2 xm2=-2 y3=3 x2=2 y15=1.5
v1 n1 0 dc {(y0==0.0 ? 1.0 : pow(x0, y0))}
r1 n1 0 1k
v2 n2 0 dc {pow(x0, y0)}
r2 n2 0 1k
v3 n3 0 dc {(y3==0.0 ? 1.0 : pow(xm2, y3))}
r3 n3 0 1k
v4 n4 0 dc {(y15==0.0 ? 1.0 : pow(x2, y15))}
r4 n4 0 1k
v5 n5 0 dc {fmod(-7, 3)}
r5 n5 0 1k
v6 n6 0 dc {-2**2}
r6 n6 0 1k
v7 n7 0 dc {(y2==0.0 ? 1.0 : pow(x0, y2))}
r7 n7 0 1k
.op
.print dc format=raw file=xy_ok.raw v(n1) v(n2) v(n3) v(n4) v(n5) v(n6) v(n7)
.end
