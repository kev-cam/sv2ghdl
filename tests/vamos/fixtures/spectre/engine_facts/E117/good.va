`include "disciplines.vams"
// E117: a plain Verilog-A resistor (vamos-authored)
module good(a, b);
  inout a, b; electrical a, b;
  parameter real r = 1000.0;
  analog I(a, b) <+ V(a, b) / r;
endmodule
