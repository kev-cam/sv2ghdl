* the same diode without ik, as vamos renders it for Xyce
* generated by vamos
Vd d 0 DC 1.0
Rd d da 100.0
D1 da 0 dm
.model dm d level=1 is=1e-14 n=1.0 nbv=1.0 eg=1.124481
.options device temp=27.0 tnom=27.0 gmin=1e-12
.OP
.PRINT DC FORMAT=RAW FILE=noik.raw V(DA) I(VD)
.end
