* XDM INDEPENDENT_SOURCES v_sources as vamos renders it for Xyce (V7: an exp source, td2 at 600 us)
* generated by vamos
V5 net3 0 DC 1.0
V3 net5 0 DC 5.0
V7 net1 0 DC 0.0 EXP(0.0 1.0 0.0001 2e-05 0.0006 4e-05)
V1 net7 0 DC 0.0 AC 0.0 0.0 SIN(0.0 1.0 1000.0 0.0 0.0 0.0)
V9 net9 0 DC 1.0 SIN(1.0 1.0 1000.0 0.0 0.0 0.0)
V11 net11 0 DC 1.0 PULSE(1.0 10.0 5e-05 5e-05 7e-05 0.0002 0.0004)
R7 net1 V8 1000.0
R8 0 V8 2000.0
R6 0 V6 2000.0
R5 net3 V6 1000.0
R4 0 V4 2000.0
R3 net5 V4 1000.0
R1 net7 V2 1000.0
R2 0 V2 2000.0
R9 net9 V10 1000.0
R10 0 V10 2000.0
R12 V12 0 1000.0
R11 net11 V12 1000.0
.options device temp=27.0 tnom=27.0 gmin=1e-12
.options timeint method=TRAP
.TRAN 1e-06 0.001 0.0 2e-05
.PRINT TRAN FORMAT=RAW FILE=vamos_a1.raw V(*) I(V11) I(V1) I(V3) I(V5) I(V7) I(V9)
.end
