* XDM INDEPENDENT_SOURCES i_sources as vamos renders it for Xyce (I44: an exp source, td2 at 600 us)
* generated by vamos
I33 net010 0 DC 1.0
I22 net06 0 DC 5.0
I11 net8 0 DC 0.0 SIN(0.0 1.0 1000.0 0.0 0.0 0.0)
I55 net6 0 DC 1.0 SIN(1.0 1.0 1000.0 0.0 0.0 0.0)
I77 net7 0 DC 1.0 AC 0.5 0.0 SIN(1.0 1.0 1000.0 0.0 0.0 0.0)
I66 net12 0 DC 1.0 PULSE(1.0 10.0 5e-05 5e-05 7e-05 0.0002 0.0004)
I44 net08 0 DC 0.0 EXP(0.0 1.0 0.0001 2e-05 0.0006 4e-05)
R4 net08 0 1000.0
R3 net010 0 1000.0
R2 net06 0 1000.0
R1 net8 0 1000.0
R5 net6 0 1000.0
R6 net12 0 1000.0
R7 net7 0 1000.0
.options device temp=27.0 tnom=27.0 gmin=1e-12
.options timeint method=TRAP
.TRAN 1e-06 0.001 0.0 2e-05
.PRINT TRAN FORMAT=RAW FILE=vamos_a1.raw V(*) I(R1) I(R2) I(R3) I(R4) I(R5) I(R6) I(R7)
.end
