* the XDM MULTIPLICITY rlc circuit (m=2 on R, L and C, and in a subckt) as vamos renders it for Xyce,
* without the probes: Xyce's I() of an m=2 element is the total current (Spectre's R1:1)
.subckt RC_sub in out params: rval=1000.0 cval=1e-06 mval=1.0
R1 in mid {rval} m={mval}
C1 mid out {cval} m={mval}
.ends RC_sub
L1 net07 0 0.002 m=2.0
L0 net2 0 0.001
C1 net011 net07 5e-07 m=2.0
C0 net4 net2 1e-06
R1 net018 net011 2000.0 m=2.0
R0 net7 net4 1000.0
V1 net018 0 DC 0.0 SIN(0.0 2.0 10.0 0.0 0.0 0.0)
V0 net7 0 DC 0.0 SIN(0.0 2.0 10.0 0.0 0.0 0.0)
L2 net6 0 0.002 m=2.0
X1 net5 net6 RC_sub rval=2000.0 cval=5e-07 mval=2.0
V2 net5 0 DC 0.0 SIN(0.0 2.0 10.0 0.0 0.0 0.0)
.options device temp=27.0 tnom=27.0 gmin=1e-12
.options timeint method=TRAP
.TRAN 0.0001 0.1 0.0 0.002
.PRINT TRAN FORMAT=RAW FILE=rlc.raw I(R1) I(R0) I(X1:R1) I(L1) I(L0) I(L2) I(V1) I(V0) I(V2)
.end
