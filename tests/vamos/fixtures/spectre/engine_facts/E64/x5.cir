* cadence2xyce form: R device with a level-6 card
.hdl "toy_resistor.va"
.model rmod r level=6
V1 a 0 1
R1 a b rmod R=3k
R2 b 0 1k
.op
.print dc format=raw file=x5.raw v(b)
.end
