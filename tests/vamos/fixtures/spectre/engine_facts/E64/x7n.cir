* VA diode through D and level=1002001, the root the toy means pinned by a nodeset (PyMS BUGS.md C8)
.hdl "toy_diode.va"
.model dm d level=1002001 Is=1e-14 Rs=10
I1 0 a 1m
D1 a 0 dm
.nodeset v(a)=-0.6
.op
.print dc format=raw file=x7n.raw v(a)
.end
