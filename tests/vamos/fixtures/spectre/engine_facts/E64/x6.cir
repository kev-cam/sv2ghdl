* VA diode, model parameters on the card, Y form
.hdl "toy_diode.va"
.model dm diode_simple Is=1e-14 Rs=10
I1 0 a 1m
ydiode_simple d1 a 0 dm
.op
.print dc format=raw file=x6.raw v(a)
.end
