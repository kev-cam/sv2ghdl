* plain VA module on the Y form, no parameters
.hdl "vres.va"
.model vres__vamos vres
V1 a 0 1
yvres r1 a b vres__vamos
R2 b 0 1k
.op
.print dc format=raw file=y1.raw v(b)
.end
