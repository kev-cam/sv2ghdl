`include "disciplines.vams"
`include "ires_defs.include"
module ires(a, b);
  inout a, b; electrical a, b;
  parameter real r = `RDEF;
  analog I(a, b) <+ V(a, b) / r;
endmodule
