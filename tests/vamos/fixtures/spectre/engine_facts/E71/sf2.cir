* .STEP of a .param that a PULSE field reads, with .TRAN
.param vamos_x_v1_val0=0.3
V1 a 0 DC {vamos_x_v1_val0} PULSE({vamos_x_v1_val0} 1.8 1u 1n 1n 1u)
R1 a 0 1k
.STEP vamos_x_v1_val0 LIST 0.2 0.4
.TRAN 10n 3u
.PRINT TRAN FORMAT=RAW FILE=sf2.raw V(A)
.end
