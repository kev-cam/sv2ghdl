* noiseless resistor as a G element, op
V1 in 0 DC 1 AC 1
GR1 in out in out 1m
R2 out 0 1k
.OP
.PRINT DC FORMAT=RAW FILE=gres_op.raw V(OUT) I(V1)
.end
