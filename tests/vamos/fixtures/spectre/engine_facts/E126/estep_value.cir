* the same .STEP from the nominal (0.5) with a VALUE= E source: out = -2 g
.param g=0.5
V1 in 0 DC -2
R1 in a 1000.0
E1 out 0 VALUE={g*V(a)}
R2 out 0 1000.0
.STEP g LIST 0.5 0.75 2
.OP
.PRINT DC FORMAT=RAW FILE=estep_value.raw V(OUT)
.end
