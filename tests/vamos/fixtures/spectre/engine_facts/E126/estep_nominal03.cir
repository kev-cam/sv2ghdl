* the same .STEP with the .param's nominal at 0.3, a value the list does not start with: out = -2 g
.param g=0.3
V1 in 0 DC -2
R1 in a 1000.0
E1 out 0 a 0 {g}
R2 out 0 1000.0
.STEP g LIST 0.5 0.75 2
.OP
.PRINT DC FORMAT=RAW FILE=estep_nominal03.raw V(OUT)
.end
