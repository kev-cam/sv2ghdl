* a .DC of the .param that a linear E source's gain reads, starting at the .param's nominal (0.5): out = -2 g
.param g=0.5
V1 in 0 DC -2
R1 in a 1000.0
E1 out 0 a 0 {g}
R2 out 0 1000.0
.DC g LIST 0.5 0.75 2
.PRINT DC FORMAT=RAW FILE=edc.raw V(OUT)
.end
