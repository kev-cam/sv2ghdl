* waveform sources without DC: .OP
V1 a 0 PULSE(0.3 1.8 1u 1n 1n 1u)
R1 a 0 1k
V2 b 0 SIN(0.5 1 1k 1u 0 90)
R2 b 0 1k
V3 c 0 EXP(0.2 1 1u 1u 3u 1u)
R3 c 0 1k
V4 d 0 PWL 0 0.7 1u 1
R4 d 0 1k
V5 e 0 PWL 1u 0.6 2u 1
R5 e 0 1k
.OP
.PRINT DC FORMAT=RAW FILE=nodc.raw V(A) V(B) V(C) V(D) V(E)
.end
