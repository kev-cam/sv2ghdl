* pow(0,0) and the guarded form on Xyce
.param x0=0 y0=0
v1 n1 0 dc {pow(x0, y0)}
r1 n1 0 1k
v2 n2 0 dc {(y0==0.0 ? 1.0 : pow(x0, y0))}
r2 n2 0 1k
.op
.print dc format=raw file=pow00.raw v(n1) v(n2)
.end
