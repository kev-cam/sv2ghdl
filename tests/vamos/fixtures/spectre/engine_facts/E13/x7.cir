* dc sweep of a global parameter, with .step over a model parameter
.param rval=1k
V1 in 0 DC 1
R1 in out {rval}
D1 out 0 dmod
.model dmod d is=1e-14
.dc rval 1k 3k 1k
.step dmod:is list 1e-14 1e-12
.print dc format=raw file=x7a.raw v(out) i(v1)
.end
