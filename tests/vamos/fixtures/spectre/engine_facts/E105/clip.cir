* XDM DIODE_CLIPPER diodeClipper as vamos renders it for Xyce (maxstep T/50 = 40 us)
* generated by vamos
.model diodea d level=1 is=4e-10 rs=0.105 n=1.48 tt=8e-07 cjo=1.95e-11 vj=0.4 m=0.38 eg=1.36 xti=-8.0 kf=0.0 af=1.0 fc=0.9 bv=600.0 ibv=0.0001 fcs=0.9 nbv=1.0
.model diodep d level=1 is=4e-10 rs=0.105 n=1.48 tt=8e-07 cjo=1.95e-11 vj=0.4 m=0.38 eg=1.36 xti=-8.0 kf=0.0 af=1.0 fc=0.9 bv=600.0 ibv=0.0001 fcs=0.9 nbv=1.0
D2 0 N03179 diodea
D1 N03179 N04104 diodep
C1 N03179 N03334 4.7e-07
R4 N03334 0 5600.0
R3 N03179 0 3300.0
R2 N04104 N03179 3300.0
R1 N03179 N04173 1000.0
V2 N04173 0 DC 0.0 SIN(0.0 10.0 1000.0 0.0 0.0 0.0)
V1 N04104 0 DC 5.0
.options device temp=27.0 tnom=27.0 gmin=1e-12
.options timeint method=TRAP
.TRAN 2e-06 0.002 0.0 4e-05
.PRINT TRAN FORMAT=RAW FILE=vamos_a1.raw V(*) I(V1) I(V2)
.end
