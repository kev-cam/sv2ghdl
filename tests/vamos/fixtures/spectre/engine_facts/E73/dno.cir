* hierarchical noise contributions
.subckt half a b
R1 a b 1k
.ends half
V1 in 0 DC 1 AC 1 0
X1 in out half
R2 out 0 1k
.NOISE V(out) V1 DEC 1 1k 10k
.PRINT NOISE FILE=dno.prn ONOISE INOISE DNO(X1:R1) DNO(R2)
.end
