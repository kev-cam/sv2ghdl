* E128: the letter-device route to a CMC module, only level on the card and the instance parameters on the M line (bsimcmg 107.0.0, level 107)
.hdl "@CMC@/bsimcmg_107.0.0/code/bsimcmg.va"
.model nch nmos level=107
vdrain drain 0 DC 0.1
vgate gate 0 DC 1.0
MX1 drain gate 0 0 nch L=3e-08 NFIN=10
.DC vgate 0 1 0.5
.PRINT DC FORMAT=RAW FILE=bsimcmg107_letter.raw I(vdrain)
.end
