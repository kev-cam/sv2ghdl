* E66's nan.va, which reads $abstime, on PyMS's letter device
.hdl "nan.va"
.model nanv__vamos nanv
ynanv X1 a nanv__vamos
R1 a 0 1000.0
.OP
.PRINT DC FORMAT=RAW FILE=abstime.raw V(A)
.end
