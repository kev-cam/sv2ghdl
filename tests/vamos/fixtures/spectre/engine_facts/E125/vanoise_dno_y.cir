* the noisy Verilog-A resistor's own noise contribution printed under its Y name, DNO(YNVR!X1)
.hdl "nvr.va"
V1 a 0 DC 1.0 AC 1 0
.model nvr__vamos nvr
ynvr X1 a b nvr__vamos
R2 b 0 1000.0
.NOISE V(B) V1 DEC 1 1K 10K
.PRINT NOISE FILE=vanoise_dno_y.prn DNO(YNVR!X1) ONOISE INOISE
.end
