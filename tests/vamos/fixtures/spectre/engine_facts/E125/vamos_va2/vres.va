`include "disciplines.vams"
// e2e 8: a plain Verilog-A resistor without xyce attributes; default r = 2000 (vamos-authored)
module vres(a, b);
  inout a, b; electrical a, b;
  parameter real r = 2000.0;
  analog I(a, b) <+ V(a, b) / r;
endmodule
