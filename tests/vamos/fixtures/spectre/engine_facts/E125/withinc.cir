* ires.va named in its own directory, the include beside it (lib/ires.va, lib/ires_defs.include)
.hdl "lib/ires.va"
V1 a 0 DC 1.0
.model ires__vamos ires
yires X1 a 0 ires__vamos
.OP
.PRINT DC FORMAT=RAW FILE=withinc.raw I(V1)
.end
