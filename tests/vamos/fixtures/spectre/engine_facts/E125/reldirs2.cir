* e2e 8 on Xyce with both Verilog-A modules named by relative .hdl paths that hold a directory (vamos_va1/, vamos_va2/: one directory each)
.hdl "vamos_va1/vares.va"
.hdl "vamos_va2/vres.va"
.model rmod r
V1 a 0 DC 1.0
.model vares__vamos r level=6
rX1 a b vares__vamos R=3000.0
R2 b 0 1000.0
.model vres__vamos vres
yvres X2 a c vres__vamos
R3 c 0 1000.0
R4 a d rmod 3000.0
R5 d 0 1000.0
.options device temp=27.0 tnom=27.0 gmin=1e-12
.OP
.PRINT DC FORMAT=RAW FILE=reldirs2.raw V(B) V(C) V(D)
.end
