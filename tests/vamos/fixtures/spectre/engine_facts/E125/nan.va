`include "disciplines.vams"
module nanv(a);
  inout a; electrical a;
  analog V(a) <+ ($abstime > 1u) ? sqrt(-1.0 - V(a)*0) : 1.0;
endmodule
