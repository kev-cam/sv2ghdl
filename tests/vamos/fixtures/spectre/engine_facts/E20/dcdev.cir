* dc sweep of a device parameter
V1 in 0 1
R1 in out 1k
R2 out 0 1k
D1 out 0 DMOD
.MODEL DMOD D IS=1e-14
.DC R1:R LIST 1k 3k
.PRINT DC FORMAT=RAW FILE=dcdev.raw V(OUT)
.end
