* e2e 25's Xyce noise deck at XI2:MID, its 0 A input (5.6's vamos_nin1) placed in the divider body and named by its top-level name
.subckt divider in out params: vamos_mfactor=1.0
r3 in Mid 1000.0 m={vamos_mfactor}
r4 Mid out 1000.0 m={vamos_mfactor}
C0 Mid 0 1e-09 m={vamos_mfactor}
ivamos_nin1 Mid 0 DC 0.0 AC 1 0
.ends divider
xI2 net1 out divider
R0 out 0 2000.0
V0 net1 0 DC 1.0
.options device temp=27.0 tnom=27.0 gmin=1e-12
.NOISE V(XI2:MID) IVAMOS_NIN1 DEC 1 1.0 100.0
.PRINT NOISE FILE=nin_e25.prn DNO(R0) DNO(XI2:R3) DNO(XI2:R4) ONOISE INOISE
.end
