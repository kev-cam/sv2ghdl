* .NOISE across two nodes with the last field (pts_per_summary) as 0: V(OUT,0) on the deck with a subckt
.subckt half a b
R1 a b 1000.0
.ends half
V1 in 0 DC 0 AC 1
X1 in out half
R2 out 0 1000.0
.NOISE V(OUT,0) V1 DEC 1 1K 10K 0
.PRINT NOISE FILE=pair_sub_0.prn ONOISE INOISE
.end
