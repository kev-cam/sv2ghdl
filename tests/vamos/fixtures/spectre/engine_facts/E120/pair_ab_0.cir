* .NOISE across two nodes with the last field (pts_per_summary) as 0: V(A,B) on the flat ladder
V1 in 0 DC 0 AC 1
R1 in a 1000.0
R2 a b 1000.0
R3 b 0 1000.0
.NOISE V(A,B) V1 DEC 1 1K 10K 0
.PRINT NOISE FILE=pair_ab_0.prn ONOISE INOISE
.end
