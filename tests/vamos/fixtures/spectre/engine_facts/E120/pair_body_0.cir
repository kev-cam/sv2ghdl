* vamos's render of a noise output across two nodes of a subckt body (I2.Mid I2.M2), its 0 A input in the body
v1 in 0 DC 1.0
r1 in out 1000.0
r2 out 0 1000.0
.subckt cell a params: vamos_mfactor=1.0
r3 a Mid 1000.0 m={vamos_mfactor}
r4 Mid M2 1000.0 m={vamos_mfactor}
r5 M2 0 1000.0 m={vamos_mfactor}
ivamos_nin1 Mid M2 DC {0.0*vamos_mfactor} AC 1 0
.ends cell
xI2 out cell
.options device temp=27.0 tnom=27.0 gmin=1e-12
.NOISE V(XI2:MID,XI2:M2) XI2:IVAMOS_NIN1 DEC 1 1.0 10.0 0
.PRINT NOISE FILE=pair_body_0.prn DNO(R1) DNO(R2) DNO(XI2:R3) DNO(XI2:R4) DNO(XI2:R5) ONOISE
.end
