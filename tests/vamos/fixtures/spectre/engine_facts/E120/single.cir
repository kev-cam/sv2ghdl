* .NOISE at one node, V(OUT), on the deck with a subckt
.subckt half a b
R1 a b 1000.0
.ends half
V1 in 0 DC 0 AC 1
X1 in out half
R2 out 0 1000.0
.NOISE V(OUT) V1 DEC 1 1K 10K
.PRINT NOISE FILE=single.prn ONOISE INOISE
.end
