* .PRINT NOISE with VM(OUT) and VP(OUT) beside ONOISE and INOISE
V1 in 0 DC 0 AC 1
R1 in out 1000.0
R2 out 0 1000.0
.NOISE V(OUT) V1 DEC 1 1K 10K
.PRINT NOISE FILE=vm.prn ONOISE INOISE VM(OUT) VP(OUT)
.end
