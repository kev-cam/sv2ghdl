* vamos's render of a noise output across two nodes with r3 swept at one frequency: .STEP, a DATA= grid and the last field
v1 in 0 DC 1.0 AC 1 0
r1 in a 1000.0
r2 a b 1000.0
r3 b 0 1000.0
.options device temp=27.0 tnom=27.0 gmin=1e-12
.STEP R3:R LIST 1000.0 2000.0
.data vamos_f_vamos_a1
+ hertz
+ 1000.0
.enddata
.NOISE V(A,B) V1 DATA=vamos_f_vamos_a1 0
.PRINT NOISE FILE=pair_data_0.prn DNO(R1) DNO(R2) DNO(R3) ONOISE VM(A,B) INOISE
.end
