* noise with AC 2
V1 in 0 DC 1 AC 2
R1 in out 1k
R2 out 0 1k
.NOISE V(out) V1 DEC 1 1k 10k
.PRINT NOISE FILE=nzac2.prn ONOISE INOISE
.end
