* noise with AC 0
V1 in 0 DC 1 AC 0
R1 in out 1k
R2 out 0 1k
.NOISE V(out) V1 DEC 1 1k 10k
.PRINT NOISE FILE=nzac0.prn ONOISE INOISE
.end
