// sub.scs line 1
R1 (vdd d) resistor r=VDD*1k
