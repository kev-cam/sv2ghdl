// general-purpose binning with an inline subcircuit, if / else if / else
simulator lang=spectre
inline subckt npn_mod (c b e s)
    parameters area=5e-12
    if ( area < 100e-12 ) {
        npn_mod (c b e s) npn10x10
    } else if ( area < 400e-12 ) {
        npn_mod (c b e s) npn20x20
    } else {
        npn_mod (c b e s) npn_default
    }
ends npn_mod
