// model parameter values expressed with function calls, grouping and a builtin constant
parameters p1=2 p2=3
model RMOD resistor tc1=p1+p2 tc2=sqrt(p1*p2) tc3=3+atan(p1/p2) rsh=(p1+p2)/p1 scale=M_PI*p1
