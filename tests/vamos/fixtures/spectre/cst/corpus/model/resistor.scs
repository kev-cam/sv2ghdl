// resistor model whose parameters are netlist-parameter expressions
parameters p1=4 p2=5
model RESMOD resistor tc1=p1+p2 tc2=sqrt(p1*p2)
