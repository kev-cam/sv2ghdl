// builtin algebraic / trigonometric function calls
simulator lang=spectre
parameters p1=1 p2=2
parameters r=sqrt(p1+p2) t=3+atan(p1/p2)
parameters ang=atan2(p1,p2) pw=pow(p1,p2)
parameters lg=log(p2) ex=exp(p1)
parameters lo=min(p1,p2) hi=max(p1,p2) h=hypot(p1,p2)
parameters nest=sqrt(pow(p1,p2))
