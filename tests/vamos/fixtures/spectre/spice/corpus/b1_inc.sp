* t
.include ./foo.sp
.hdl bar.va
.width out=80
