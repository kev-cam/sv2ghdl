* t
.data tbl
+ a b
+ 1 2
+ 3 4
.enddata
