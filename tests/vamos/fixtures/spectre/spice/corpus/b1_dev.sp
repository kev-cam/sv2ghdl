* t
D1 a k dmod
M1 d g s b nmos w=1u l=1u
Q1 c b e npn
Q2 c b e s t pnp area=2
B1 out 0 v=1
