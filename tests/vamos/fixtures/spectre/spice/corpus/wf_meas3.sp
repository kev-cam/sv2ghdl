* t
.meas tran m3 TRIG v(a) VAL=1 TD=1n RISE=1 TARG v(b) VAL=2
