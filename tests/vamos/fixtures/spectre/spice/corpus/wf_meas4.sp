* t
.meas tran delay AVG v(out) TRIG v(a) VAL=1 TARG v(b) VAL=2
