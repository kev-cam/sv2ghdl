* t
.meas tran m2 DERIV v(a) WHEN v(b)=0.5 RISE=2 TD=1n
