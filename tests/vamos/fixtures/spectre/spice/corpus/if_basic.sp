* t
.if (a>1)
R1 a b 1k
.else
R1 a b 2k
.endif
