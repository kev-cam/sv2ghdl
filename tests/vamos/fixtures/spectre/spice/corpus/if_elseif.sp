* t
.if (a==1)
R1 a b 1k
.elseif (a==2)
R1 a b 2k
.elseif (a==3)
R1 a b 3k
.else
R1 a b 4k
.endif
