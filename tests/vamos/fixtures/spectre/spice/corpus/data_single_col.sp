* t
.data freqs
+ f
+ 1k
+ 2k
+ 3k
.enddata
