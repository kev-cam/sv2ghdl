* // e2e 6: alter dev=Vdif param=type between an op and a tran, then back to dc (the UG op-amp pattern)
* generated by vamos
Vdif a 0 DC 0.0
R1 a 0 1000.0
.options device temp=27.0 tnom=27.0 gmin=1e-12
.OP
.PRINT DC FORMAT=RAW FILE=vamos_a1.raw V(A) I(VDIF)
.end
