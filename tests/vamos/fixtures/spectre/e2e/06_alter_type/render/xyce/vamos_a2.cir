* // e2e 6: alter dev=Vdif param=type between an op and a tran, then back to dc (the UG op-amp pattern)
* generated by vamos
Vdif a 0 DC 0.0 PULSE(0.0 2.0 1e-08 2e-15 2e-15 1e-06)
R1 a 0 1000.0
.options device temp=27.0 tnom=27.0 gmin=1e-12
.options timeint method=TRAP
.TRAN 1.9999999999999997e-09 2e-06 0.0 4e-08
.PRINT TRAN FORMAT=RAW FILE=vamos_a2.raw V(A) I(VDIF)
.end
