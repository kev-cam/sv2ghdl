* // e2e 20: alter mod= (sec. 5.3, sec. 7.2): the Xyce state replay prints the altered cards in every later deck
* generated by vamos
I1 0 d DC 0.001
D1 d 0 dm
.model dm d level=1 is=1e-14 eg=1.124481
I2 d2 0 DC 0.001
D2 d2 0 dz
.model dz d level=1 is=1e-14 bv=5.0 eg=1.124481
.options device temp=27.0 tnom=27.0 gmin=1e-12
.OP
.PRINT DC FORMAT=RAW FILE=vamos_a1.raw V(D) V(D2)
.end
