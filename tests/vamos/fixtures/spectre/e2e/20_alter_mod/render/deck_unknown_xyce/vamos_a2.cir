* // e2e 20: an alter of a card parameter Xyce does not know (ikp): the output scan of the later deck finds
* generated by vamos
I1 0 d DC 0.001
D1 d 0 dm
.model dm d level=1 is=1e-14 ikp=0.001 eg=1.124481
.options device temp=27.0 tnom=27.0 gmin=1e-12
.OP
.PRINT DC FORMAT=RAW FILE=vamos_a2.raw V(D)
.end
