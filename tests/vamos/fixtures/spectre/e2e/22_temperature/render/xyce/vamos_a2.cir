* // e2e 22: temperature (sec. 3.10, sec. 3.9): an options-free netlist at 27 C, a diode card without eg at 127 C,
* generated by vamos
Rn n1 0 1000.0
I1 0 d DC 0.001
D1 d 0 dnoeg
.model dnoeg d level=1 is=1e-14 eg=1.124481
.model fast_1x1 nmos level=3 vto={(temp>=27.0 ? 0.9 : 0.75)} phi=0.7 gamma=0.0 nsub=1.13e+16 mjsw=0.3333333333333333 badmos3=1.0
.model m075 nmos level=3 vto=0.75 phi=0.7 gamma=0.0 nsub=1.13e+16 mjsw=0.3333333333333333 badmos3=1.0
.model m090 nmos level=3 vto=0.9 phi=0.7 gamma=0.0 nsub=1.13e+16 mjsw=0.3333333333333333 badmos3=1.0
Vg g 0 DC 2.0
Vd1 d1 0 DC 3.0
Vd2 d2 0 DC 3.0
Vd3 d3 0 DC 3.0
M1 d1 g 0 0 fast_1x1 w=1e-05 l=2e-06 nrd=0.0 nrs=0.0
M2 d2 g 0 0 m075 w=1e-05 l=2e-06 nrd=0.0 nrs=0.0
M3 d3 g 0 0 m090 w=1e-05 l=2e-06 nrd=0.0 nrs=0.0
ivamos_nin1 n1 0 DC 0.0
.options device temp=27.0 tnom=27.0 gmin=1e-12
.OP
.PRINT DC FORMAT=RAW FILE=vamos_a2.raw V(D) I(VD1) I(VD2) I(VD3)
.end
