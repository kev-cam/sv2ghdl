// e2e 7: a SPICE-mode file with .op .ac .tran, and a Spectre file holding a SPICE model section
simulator lang=spice
v1 in 0 dc 1 ac 1 sin(0 1 1k)
r1 in out 1k
c1 out 0 1u
v2 x 0 dc 0.6
d1 x 0 dm
.include "models.scs"
.op
.ac dec 10 1 1meg
.tran 1u 1m
.end
