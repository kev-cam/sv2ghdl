* // e2e 7: a SPICE-mode file with .op .ac .tran, and a Spectre file holding a SPICE model section
* generated by vamos
v1 in 0 DC 1.0 AC 1.0 0.0 SIN(0.0 1.0 1000.0 0.0 0.0 0.0)
r1 in out 1000.0
c1 out 0 1e-06
v2 x 0 DC 0.6
d1 x 0 dm
.model dm d level=1 is=1e-14 n=1.5 nbv=1.0 eg=1.124481
.options device temp=27.0 tnom=27.0 gmin=1e-12
.OP
.PRINT DC FORMAT=RAW FILE=vamos_a1.raw V(*) I(V1) I(V2)
.end
