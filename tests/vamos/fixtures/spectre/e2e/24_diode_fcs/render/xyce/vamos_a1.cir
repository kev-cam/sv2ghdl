* // e2e 24: a diode's sidewall capacitance with fc=0.3 and no fcs: Spectre's fcs=fc (ref5 p.305), not 0.5
* generated by vamos
V1 a 0 DC {vamos_x_V1_dc} AC 1.0 0.0
D1 a 0 dsw pj=2.0
.model dsw d level=1 is=1e-18 cjsw=1e-12 vjsw=0.8 mjsw=0.5 fc=0.3 fcs=0.3 eg=1.124481 cjo=1e-30
.options device temp=27.0 tnom=27.0 gmin=1e-12
.param vamos_x_V1_dc=0.0
.STEP vamos_x_V1_dc LIST -1.0 0.0 0.2 0.24 0.3 0.4 0.5 0.6
.data vamos_f_vamos_a1
+ hertz
+ 1000000.0
.enddata
.AC DATA=vamos_f_vamos_a1
.PRINT AC FORMAT=RAW FILE=vamos_a1.raw V(*) I(V1)
.end
