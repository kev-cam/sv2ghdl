* // e2e 26: a subckt default that reads a swept parameter follows the sweep (E53's pattern)
* generated by vamos
.param rval=1000.0
.param rdep={rval*2.0}
V1 in 0 DC 1.0
X1 in o1 rsec
X2 in o2 rsec2
X3 in o3 rsec r=3000.0
.subckt rsec a b params: r={rdep} vamos_mfactor=1.0
R1 a b {r} m={vamos_mfactor}
R2 b 0 1000.0 m={vamos_mfactor}
.ends rsec
.subckt rsec2 a b params: r={rval*3.0} vamos_mfactor=1.0
R1 a b {r} m={vamos_mfactor}
R2 b 0 1000.0 m={vamos_mfactor}
.ends rsec2
.options device temp=27.0 tnom=27.0 gmin=1e-12
.OP
.PRINT DC FORMAT=RAW FILE=vamos_a1.raw V(*) I(V1)
.end
