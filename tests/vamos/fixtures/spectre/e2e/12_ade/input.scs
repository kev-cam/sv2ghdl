// Design: vamos_e2e/rc_filter
simulator lang=spectre
global 0
parameters rval=1k cval=100n

// vamos_e2e/rc_stage/schematic
subckt rc_stage in out
    R0 (in Mid) resistor r=rval
    C0 (Mid 0) capacitor c=cval
    R1 (Mid out) resistor r=rval
ends rc_stage

// vamos_e2e/rc_filter/schematic
V0 (net\<3\> 0) vsource type=pulse val0=0.2 val1=1 period=1m delay=0 rise=1u fall=1u width=500u
I2 (net\<3\> out) rc_stage
C1 (out 0) capacitor c=cval
simulatorOptions options temp=27
tran tran stop=2m errpreset=moderate
