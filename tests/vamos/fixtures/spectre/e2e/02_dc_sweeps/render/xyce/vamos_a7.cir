* // e2e 2: dc sweeps of a source, temp, a top-level parameter, a model parameter, a subckt parameter
* generated by vamos
.param rtop=1000.0
V1 in 0 DC 1.0
R1 in mid {rtop}
X1 mid out cell r=1000.0
X2 out 0 cell r=1000.0
X3 out 0 cell2
.subckt cell a b params: r=1000.0 vamos_mfactor=1.0
R1 a b {r} m={vamos_mfactor}
.ends cell
.subckt cell2 a b params: vamos_mfactor=1.0
R1 a b 2000.0 m={vamos_mfactor}
.ends cell2
Vd d 0 DC 1.0
Rd d da 100.0
D1 da 0 dm
.model dm d level=1 is=1e-14 n=1.0 nbv=1.0 eg=1.124481
Vg g 0 DC 1.2
Vm dm 0 DC 1.2
M1 dm g 0 0 nch w=2e-06 l=5e-07 nrd=0.0 nrs=0.0
.model nch nmos level=9 vth0=0.4 tox=4e-09 toxm=4e-09 u0=0.04 capmod=2.0
.options device temp=27.0 tnom=27.0 gmin=1e-12
.DC X3:R1:R LIST 1000.0 2000.0 4000.0
.PRINT DC FORMAT=RAW FILE=vamos_a7.raw V(OUT) V(DA) I(V1) I(VD) I(VM) I(X2:R1) I(X3:R1)
.end
