* // e2e 21: resistors (sec. 3.8): r = 0, a card's r folded into its instances, an instance scale, isnoisy=no
* generated by vamos
V1 in 0 DC 1.0
R0 in a 0.0
Ra a 0 1000.0
.model rcard r
R1 in b rcard 2000.0
.model rgeo r
R2 b 0 rgeo 653.3333333333335 w=2e-06 l=1e-05
R3 in c rgeo 565.7142857142857 w=4e-06 l=2e-05
R4 c 0 1000.0
Vn n1 0 DC 0.0
Rn n1 nq 1000.0
gRq nq 0 nq 0 0.001
.options device temp=27.0 tnom=27.0 gmin=1e-12
.OP
.PRINT DC FORMAT=RAW FILE=vamos_a1.raw V(A) V(B) V(C) I(R0) V(NQ)
.end
