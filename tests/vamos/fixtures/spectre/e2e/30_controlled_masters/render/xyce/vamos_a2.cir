* // e2e 30: controlled sources and the remaining masters: vccs, ccvs, cccs, mutual_inductor, jfet, mos1, mos2
* generated by vamos
Vc c 0 DC 1.0
Vs c s1 DC 0.0
Rs1 s1 0 1000.0
vIp c s2 DC 0.0
Rs2 s2 0 2000.0
G1 0 o1 c 0 0.001
Ro1 o1 0 1000.0
H1 o2 0 Vs 1000.0
H2 o3 0 vIp 1000.0
F1 0 o4 Vs 2.0
Ro4 o4 0 1000.0
F2 0 o5 vIp 2.0
Ro5 o5 0 1000.0
Iac 0 p DC 0.0 AC 0.001 0.0
L1 p 0 0.001
L2 s 0 0.009
K1 L1 L2 0.5
Vds dd 0 DC 1.5
Vgs g 0 DC 2.0
vIj dd dj DC 0.0
J1 dj 0 0 njf
.model njf njf level=1 vto=-2.0 beta=0.001 lambda=0.01 kf=0.0
vI1 dd d1 DC 0.0
M1 d1 g 0 0 nm1 w=1e-05 l=2e-06 nrd=0.0 nrs=0.0
.model nm1 nmos level=1 vto=0.7 kp=0.0001 lambda=0.02 phi=0.7 gamma=0.0 nsub=1.13e+16 tpg=1.0 tox=1e-07 mjsw=0.3333333333333333
vI2 dd d2 DC 0.0
M2 d2 g 0 0 nm2 w=1e-05 l=2e-06 nrd=0.0 nrs=0.0
.model nm2 nmos level=2 vto=0.7 kp=0.0001 tox=1e-07 phi=0.7 gamma=0.0 nsub=1.13e+16 tpg=1.0 mjsw=0.3333333333333333
.options device temp=27.0 tnom=27.0 gmin=1e-12
.AC DEC 1 1000.0 10000.0
.PRINT AC FORMAT=RAW FILE=vamos_a2.raw V(*) I(VI1) I(VI2) I(VIJ) I(VIP) I(L1) I(L2) I(VC) I(VDS) I(VGS) I(VS)
.end
