* // e2e 9: a BSIM4 model group binned in l and w; an edge geometry exactly on lmin; a MOS without l
* generated by vamos
.model nch.1 nmos level=54 lmin=1e-07 lmax=1e-06 wmin=1e-07 wmax=1e-06 vth0=0.4 toxe=2e-09 rdsmod=1.0 igbmod=1.0
.model nch.2 nmos level=54 lmin=1e-06 lmax=1e-05 wmin=1e-07 wmax=1e-06 vth0=0.45 toxe=2e-09 rdsmod=1.0 igbmod=1.0
.model nch.3 nmos level=54 lmin=1e-07 lmax=1e-06 wmin=1e-06 wmax=1e-05 vth0=0.5 toxe=2e-09 rdsmod=1.0 igbmod=1.0
.model nch.4 nmos level=54 lmin=1e-06 lmax=1e-05 wmin=1e-06 wmax=1e-05 vth0=0.55 toxe=2e-09 rdsmod=1.0 igbmod=1.0
.model b4ref nmos level=54 vth0=0.55 toxe=2e-09 rdsmod=1.0 igbmod=1.0
.model b1ref nmos level=54 vth0=0.4 toxe=2e-09 rdsmod=1.0 igbmod=1.0
Vg g 0 DC 1.2
Vd1 d1 0 DC 1.2
Vd2 d2 0 DC 1.2
Vd3 d3 0 DC 1.2
Vd4 d4 0 DC 1.2
Vd5 d5 0 DC 1.2
Vd6 d6 0 DC 1.2
Vd7 d7 0 DC 1.2
Vd8 d8 0 DC 1.2
M1 d1 g 0 0 nch.1 w=5e-07 l=5e-07 nrd=0.0 nrs=0.0
M2 d2 g 0 0 nch.2 w=5e-07 l=2e-06 nrd=0.0 nrs=0.0
M3 d3 g 0 0 nch.3 w=2e-06 l=5e-07 nrd=0.0 nrs=0.0
M4 d4 g 0 0 nch.4 w=2e-06 l=1e-06 nrd=0.0 nrs=0.0
M5 d5 g 0 0 b4ref w=2e-06 l=1e-06 nrd=0.0 nrs=0.0
M6 d6 g 0 0 nch.4 w=5e-06 l=5e-06 nrd=0.0 nrs=0.0
M7 d7 g 0 0 b4ref w=5e-06 l=5e-06 nrd=0.0 nrs=0.0
M8 d8 g 0 0 b1ref w=2e-06 l=2e-06 nrd=0.0 nrs=0.0
.options device temp=27.0 tnom=27.0 gmin=1e-12
.OP
.PRINT DC FORMAT=RAW FILE=vamos_a1.raw V(*) I(VD1) I(VD2) I(VD3) I(VD4) I(VD5) I(VD6) I(VD7) I(VD8) I(VG)
.end
