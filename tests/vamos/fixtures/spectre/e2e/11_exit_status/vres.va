`include "disciplines.vams"
// e2e 11: a plain Verilog-A resistor, r = 2000 by default (vamos-authored)
module vres(a, b);
  inout a, b; electrical a, b;
  parameter real r = 2000.0;
  analog I(a, b) <+ V(a, b) / r;
endmodule
