// e2e 11: SIGINT during a long tran: exit status 3, op1 and the partial tr1 written (a 40-stage RC ladder)
simulator lang=spectre
V1 (n0 0) vsource type=sine sinedc=0 ampl=1 freq=1k
R1 (n0 n1) resistor r=100
C1 (n1 0) capacitor c=10n
R2 (n1 n2) resistor r=100
C2 (n2 0) capacitor c=10n
R3 (n2 n3) resistor r=100
C3 (n3 0) capacitor c=10n
R4 (n3 n4) resistor r=100
C4 (n4 0) capacitor c=10n
R5 (n4 n5) resistor r=100
C5 (n5 0) capacitor c=10n
R6 (n5 n6) resistor r=100
C6 (n6 0) capacitor c=10n
R7 (n6 n7) resistor r=100
C7 (n7 0) capacitor c=10n
R8 (n7 n8) resistor r=100
C8 (n8 0) capacitor c=10n
R9 (n8 n9) resistor r=100
C9 (n9 0) capacitor c=10n
R10 (n9 n10) resistor r=100
C10 (n10 0) capacitor c=10n
R11 (n10 n11) resistor r=100
C11 (n11 0) capacitor c=10n
R12 (n11 n12) resistor r=100
C12 (n12 0) capacitor c=10n
R13 (n12 n13) resistor r=100
C13 (n13 0) capacitor c=10n
R14 (n13 n14) resistor r=100
C14 (n14 0) capacitor c=10n
R15 (n14 n15) resistor r=100
C15 (n15 0) capacitor c=10n
R16 (n15 n16) resistor r=100
C16 (n16 0) capacitor c=10n
R17 (n16 n17) resistor r=100
C17 (n17 0) capacitor c=10n
R18 (n17 n18) resistor r=100
C18 (n18 0) capacitor c=10n
R19 (n18 n19) resistor r=100
C19 (n19 0) capacitor c=10n
R20 (n19 n20) resistor r=100
C20 (n20 0) capacitor c=10n
R21 (n20 n21) resistor r=100
C21 (n21 0) capacitor c=10n
R22 (n21 n22) resistor r=100
C22 (n22 0) capacitor c=10n
R23 (n22 n23) resistor r=100
C23 (n23 0) capacitor c=10n
R24 (n23 n24) resistor r=100
C24 (n24 0) capacitor c=10n
R25 (n24 n25) resistor r=100
C25 (n25 0) capacitor c=10n
R26 (n25 n26) resistor r=100
C26 (n26 0) capacitor c=10n
R27 (n26 n27) resistor r=100
C27 (n27 0) capacitor c=10n
R28 (n27 n28) resistor r=100
C28 (n28 0) capacitor c=10n
R29 (n28 n29) resistor r=100
C29 (n29 0) capacitor c=10n
R30 (n29 n30) resistor r=100
C30 (n30 0) capacitor c=10n
R31 (n30 n31) resistor r=100
C31 (n31 0) capacitor c=10n
R32 (n31 n32) resistor r=100
C32 (n32 0) capacitor c=10n
R33 (n32 n33) resistor r=100
C33 (n33 0) capacitor c=10n
R34 (n33 n34) resistor r=100
C34 (n34 0) capacitor c=10n
R35 (n34 n35) resistor r=100
C35 (n35 0) capacitor c=10n
R36 (n35 n36) resistor r=100
C36 (n36 0) capacitor c=10n
R37 (n36 n37) resistor r=100
C37 (n37 0) capacitor c=10n
R38 (n37 n38) resistor r=100
C38 (n38 0) capacitor c=10n
R39 (n38 n39) resistor r=100
C39 (n39 0) capacitor c=10n
R40 (n39 n40) resistor r=100
C40 (n40 0) capacitor c=10n
op1 dc
tr1 tran stop=10 maxstep=2u
save n40
