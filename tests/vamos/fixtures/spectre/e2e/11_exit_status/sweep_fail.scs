// e2e 11: exit status 1, a sweep whose second point fails (the vcvs at gain 1): the leaf before it is written
simulator lang=spectre
parameters g=0.5
V1 (in 0) vsource dc=1
R1 (in a) resistor r=1k
C1 (a 0) capacitor c=1n
E1 (out 0 out a) vcvs gain=g
R2 (out 0) resistor r=1k
sw sweep param=g values=[0.75 1 2] {
  op1 dc
}
op9 dc
save out a
