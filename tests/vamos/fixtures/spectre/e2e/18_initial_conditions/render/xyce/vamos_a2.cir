* // e2e 18: initial conditions (sec. 5.4): ic statements under each tran ic mode, skipdc, a nodeset; the op and ac unchanged
* generated by vamos
V1 in 0 DC 1.0 AC 1.0 0.0
R1 in a 1000.0
C1 a 0 1e-09
R2 in b 1000.0
C2 b 0 1e-09
.options device temp=27.0 tnom=27.0 gmin=1e-12
.NODESET V(A)=0.5 V(B)=0.5
.data vamos_f_vamos_a2
+ hertz
+ 1000.0
.enddata
.AC DATA=vamos_f_vamos_a2
.PRINT AC FORMAT=RAW FILE=vamos_a2.raw V(IN) V(A) V(B)
.end
