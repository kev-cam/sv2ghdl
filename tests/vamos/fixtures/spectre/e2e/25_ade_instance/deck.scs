// Design: vamos_e2e/tb_divider
simulator lang=spectre
global 0

// vamos_e2e/divider/schematic
subckt divider in out
    r3 (in Mid) resistor r=1K
    r4 (Mid out) resistor r=1K
    C0 (Mid 0) capacitor c=1n
ends divider

// vamos_e2e/tb_divider/schematic
I2 (net1 out) divider
R0 (out 0) resistor r=2K
V0 (net1 0) vsource dc=1 mag=1 type=dc
ic I2.Mid=0.3
simulatorOptions options temp=27
dcOp dc
noise (out 0) noise start=1 stop=100 dec=1 iprobe=V0 annotate=status
tran tran stop=5u errpreset=moderate
save I2.Mid
