* // Generated for: spectre
* generated by vamos
.subckt divider in out params: vamos_mfactor=1.0
r3 in Mid 1000.0 m={vamos_mfactor}
r4 Mid out 1000.0 m={vamos_mfactor}
C0 Mid 0 1e-09 m={vamos_mfactor}
.ends divider
xI2 net1 out divider
R0 out 0 2000.0
V0 net1 0 DC 1.0 AC 1 0
.options device temp=27.0 tnom=27.0 gmin=1e-12
.NOISE V(OUT) V0 DEC 1 1.0 100.0
.PRINT NOISE FILE=vamos_a2.prn DNO(R0) DNO(XI2:R3) DNO(XI2:R4) ONOISE VM(OUT) INOISE
.end
