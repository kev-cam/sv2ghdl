* // Generated for: spectre
* generated by vamos
.subckt divider in out params: vamos_mfactor=1.0
r3 in Mid 1000.0 m={vamos_mfactor}
r4 Mid out 1000.0 m={vamos_mfactor}
C0 Mid 0 1e-09 m={vamos_mfactor}
.ends divider
xI2 net1 out divider
R0 out 0 2000.0
V0 net1 0 DC 1.0 AC 1.0 0.0
.options device temp=27.0 tnom=27.0 gmin=1e-12
.options timeint method=TRAP
.IC V(XI2:MID)=0.3
.TRAN 5e-09 5e-06 0.0 1.0000000000000001e-07
.PRINT TRAN FORMAT=RAW FILE=vamos_a3.raw V(*) I(V0)
.end
