* // e2e 4: noise of a 1k/1k divider, with and without an input probe, a resistor inside a subckt
* generated by vamos
V1 in 0 DC 0.0
R1 in out 1000.0
R2 out 0 1000.0
xI2 out cell
.subckt cell a params: vamos_mfactor=1.0
r3 a 0 1000000000.0 m={vamos_mfactor}
.ends cell
ivamos_nin2 out 0 DC 0.0 AC 1 0
.options device temp=27.0 tnom=27.0 gmin=1e-12
.NOISE V(OUT) IVAMOS_NIN2 DEC 1 1000.0 10000.0
.PRINT NOISE FILE=vamos_a2.prn DNO(R1) DNO(R2) DNO(XI2:R3) ONOISE
.end
