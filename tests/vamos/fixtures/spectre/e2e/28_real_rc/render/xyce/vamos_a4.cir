* #RC Low-Pass Filter
* generated by vamos
Vin in 0 DC 1.0 AC 1.0 0.0 SIN(1.0 1.0 1000.0 0.0 0.0 0.0)
R1 in out 1000.0
C1 out 0 1e-06
.options device temp=27.0 tnom=27.0 gmin=1e-12
.options timeint method=TRAP
.TRAN 0.0005 0.5 0.0 0.01
.PRINT TRAN FORMAT=RAW FILE=vamos_a4.raw V(IN) V(OUT)
.end
