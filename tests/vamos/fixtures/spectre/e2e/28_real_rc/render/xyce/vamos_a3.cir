* #RC Low-Pass Filter
* generated by vamos
Vin in 0 DC 1.0 AC 1.0 0.0 SIN(1.0 1.0 1000.0 0.0 0.0 0.0)
R1 in out 1000.0
C1 out 0 1e-06
.options device temp=27.0 tnom=27.0 gmin=1e-12
.data vamos_f_vamos_a3
+ hertz
+ 1.0
+ 1.9952623149688797
+ 3.9810717055349727
+ 7.943282347242814
+ 15.848931924611136
+ 31.622776601683793
+ 63.095734448019314
+ 125.89254117941668
+ 251.1886431509581
+ 501.18723362727235
+ 1000.0
+ 1995.262314968881
+ 3981.0717055349714
+ 7943.282347242817
+ 15848.931924611124
+ 31622.776601683792
+ 63095.734448019364
+ 125892.54117941669
+ 251188.6431509581
+ 501187.23362727195
+ 1000000.0
.enddata
.AC DATA=vamos_f_vamos_a3
.PRINT AC FORMAT=RAW FILE=vamos_a3.raw V(IN) V(OUT)
.end
