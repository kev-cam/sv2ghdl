* #RC Low-Pass Filter
* generated by vamos
Vin in 0 DC {vamos_x_Vin_dc} AC 1.0 0.0 SIN(1.0 1.0 1000.0 0.0 0.0 0.0)
R1 in out 1000.0
C1 out 0 1e-06
.options device temp=27.0 tnom=27.0 gmin=1e-12
.param vamos_x_Vin_dc=1.0
.DC vamos_x_Vin_dc 0.0 2.0 0.1
.PRINT DC FORMAT=RAW FILE=vamos_a2.raw V(IN) V(OUT)
.end
