* // e2e 17: independent sources (sec. 3.8.1): a derived dc, a pulse without edges, a given dc
* generated by vamos
V1 a 0 DC 0.3 PULSE(0.3 1.0 1e-06 1e-08 1e-08 1e-06)
R1 a 0 1000.0
V2 b 0 DC 0.0 PULSE(0.0 1.0 1e-06 3.0000000000000002e-15 3.0000000000000002e-15 1e-06)
R2 b 0 1000.0
V3 c 0 DC {vamos_x_V3_dc} AC 1.0 0.0 PULSE(0.0 1.0 1e-06 1e-08 1e-08 1e-06)
R3 c d 1000.0
D3 d 0 dm
.model dm d level=1 is=1e-14 eg=1.124481
.options device temp=27.0 tnom=27.0 gmin=1e-12
.param vamos_x_V3_dc=0.9
.DC vamos_x_V3_dc LIST 0.7 0.9
.PRINT DC FORMAT=RAW FILE=vamos_a2.raw V(A) V(B) V(C) V(D)
.end
