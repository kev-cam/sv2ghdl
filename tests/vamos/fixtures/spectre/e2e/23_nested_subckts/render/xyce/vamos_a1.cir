* // e2e 23: nested subckts, UG pp.85-86's parameter inheritance (VACASK through the lift)
* generated by vamos
.param p1=1.0
.param p2=2.0
I1 0 a1 DC 1.0
R1 a1 0 {p1}
I2 0 a2 DC 1.0
R2 a2 0 {p1+p2}
X1 0 s1 p4=8.0
.subckt s1 b params: p1=4.0 p3=5.0 p4=6.0 vamos_mfactor=1.0
I1 b n1 DC {vamos_mfactor}
R1 n1 b {p1} m={vamos_mfactor}
I2 b n2 DC {vamos_mfactor}
R2 n2 b {p2} m={vamos_mfactor}
I3 b n3 DC {vamos_mfactor}
R3 n3 b {p3} m={vamos_mfactor}
I4 b n4 DC {vamos_mfactor}
R4 n4 b {p4} m={vamos_mfactor}
I5 b n5 DC {vamos_mfactor}
R5 n5 b {p1+p2/p3} m={vamos_mfactor}
.subckt s2 b params: p3=7.0 vamos_mfactor=1.0
I1 b m1 DC {vamos_mfactor}
R1 m1 b {p1} m={vamos_mfactor}
I2 b m2 DC {vamos_mfactor}
R2 m2 b {p2} m={vamos_mfactor}
I3 b m3 DC {vamos_mfactor}
R3 m3 b {p3} m={vamos_mfactor}
I4 b m4 DC {vamos_mfactor}
R4 m4 b {p4} m={vamos_mfactor}
I5 b m5 DC {vamos_mfactor}
R5 m5 b {p1+p2/p3} m={vamos_mfactor}
.subckt s3 b params: vamos_mfactor=1.0
I1 b k1 DC {vamos_mfactor}
R1 k1 b {p3} m={vamos_mfactor}
I2 b k2 DC {vamos_mfactor}
R2 k2 b {p1*p4} m={vamos_mfactor}
.ends s3
X4 b s3 vamos_mfactor={vamos_mfactor}
.ends s2
X2 b s2 vamos_mfactor={vamos_mfactor}
X3 b s2 p3=9.0 vamos_mfactor={vamos_mfactor}
.ends s1
.options device temp=27.0 tnom=27.0 gmin=1e-12
.OP
.PRINT DC FORMAT=RAW FILE=vamos_a1.raw V(*)
.end
