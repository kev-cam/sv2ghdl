* // e2e 10: UG p.110: an inline subckt binning BJT cards by area with same-named branches
* generated by vamos
.subckt npn_mod c b e s params: area=1e-12 vamos_mfactor=1.0
qnpn_mod vamos_tn1 b e s npn20x20 m={vamos_mfactor}
vamos_tp1 c vamos_tn1 DC 0.0
.model npn20x20 npn level=1 is=3.77e-16 vaf=60.5 mje=0.3333333333333333 mjc=0.3333333333333333 fc=0.5
.ends npn_mod
.subckt npn_mod__vb1 c b e s params: area=1e-12 vamos_mfactor=1.0
qnpn_mod vamos_tn2 b e s npn10x10 m={vamos_mfactor}
vamos_tp2 c vamos_tn2 DC 0.0
.model npn10x10 npn level=1 is=3.5e-16 vaf=61.5 mje=0.3333333333333333 mjc=0.3333333333333333 fc=0.5
.ends npn_mod__vb1
.subckt npn_mod__vb2 c b e s params: area=1e-12 vamos_mfactor=1.0
qnpn_mod vamos_tn3 b e s npn_default m={vamos_mfactor}
vamos_tp3 c vamos_tn3 DC 0.0
.model npn_default npn level=1 is=3.2e-16 vaf=59.8 mje=0.3333333333333333 mjc=0.3333333333333333 fc=0.5
.ends npn_mod__vb2
vin 1 0 DC 1.0
vb 2 0 DC 0.7
vb3 3 0 DC 0.65
xq1 1 2 0 0 npn_mod area=3.5e-10
xq2 1 3 0 0 npn_mod__vb1 area=2.5e-11
xq3 1 3 0 0 npn_mod__vb2 area=1e-09
.options device temp=27.0 tnom=27.0 gmin=1e-12
.OP
.PRINT DC FORMAT=RAW FILE=vamos_a1.raw V(*) I(VB3) I(VB) I(VIN) I(XQ1:VAMOS_TP1) I(XQ2:VAMOS_TP2) I(XQ3:VAMOS_TP3)
.end
