* // e2e 3: a sweep block with dc and ac children, repeated values and a nested sweep
* generated by vamos
.param rval=1000.0
.param cval=1e-06
V1 in 0 DC 1.0 AC 1.0 0.0
R1 in out {rval}
C1 out 0 {cval}
.options device temp=27.0 tnom=27.0 gmin=1e-12
.STEP cval LIST 1e-06 2e-06
.STEP rval LIST 1000.0 1000.0 2000.0
.param vamos_op=0
.DC vamos_op LIST 0
.PRINT DC FORMAT=RAW FILE=vamos_a3.raw V(OUT) I(V1)
.end
