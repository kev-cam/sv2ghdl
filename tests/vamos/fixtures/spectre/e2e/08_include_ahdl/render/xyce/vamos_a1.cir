* // e2e 8: include section= of a library file, ahdl_include of Verilog-A resistors
* generated by vamos
.hdl "vares.va"
.hdl "vres.va"
.model rmod r
V1 a 0 DC 1.0
.model vares__vamos r level=6
rX1 a b vares__vamos R=3000.0
R2 b 0 1000.0
.model vres__vamos vres
yvres X2 a c vres__vamos
R3 c 0 1000.0
R4 a d rmod 3000.0
R5 d 0 1000.0
.options device temp=27.0 tnom=27.0 gmin=1e-12
.OP
.PRINT DC FORMAT=RAW FILE=vamos_a1.raw V(B) V(C) V(D)
.end
