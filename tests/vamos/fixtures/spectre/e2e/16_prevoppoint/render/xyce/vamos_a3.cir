* // e2e 16: prevoppoint after a tran: the AC gain at the final transient state against a fresh op
* generated by vamos
V1 in 0 DC 0.0 AC 1.0 0.0 PULSE(0.0 2.0 0.0 1e-09 1e-09 1.0)
R1 in out 1000.0
D1 out 0 dm
C1 out 0 1e-09
.model dm d level=1 is=1e-14 eg=1.124481
.options device temp=27.0 tnom=27.0 gmin=1e-12
.data vamos_f_vamos_a3
+ hertz
+ 1000.0
.enddata
.AC DATA=vamos_f_vamos_a3
.PRINT AC FORMAT=RAW FILE=vamos_a3.raw V(IN) V(OUT)
.end
