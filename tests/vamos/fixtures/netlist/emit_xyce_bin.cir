* binning
* generated by vamos
.model nch.1 nmos level=54 lmin=1e-07 lmax=2.2e-07 wmin=1e-07 wmax=1e-06 vth0=0.3 version=4.8 toxe=2e-09 u0=0.04
.model nch.2 nmos level=54 lmin=1e-07 lmax=2.2e-07 wmin=1e-06 wmax=0.0001 vth0=0.6 version=4.8 toxe=2e-09 u0=0.04
.model nch.3 nmos level=54 lmin=2.2e-07 lmax=1e-05 wmin=1e-07 wmax=1e-06 vth0=0.45 version=4.8 toxe=2e-09 u0=0.04
.model nch.4 nmos level=54 lmin=2.2e-07 lmax=1e-05 wmin=1e-06 wmax=0.0001 vth0=0.5 version=4.8 toxe=2e-09 u0=0.04
.model ref1 nmos level=54 vth0=0.3 version=4.8 toxe=2e-09 u0=0.04
.model ref2 nmos level=54 vth0=0.6 version=4.8 toxe=2e-09 u0=0.04
.model ref3 nmos level=54 vth0=0.45 version=4.8 toxe=2e-09 u0=0.04
vg g 0 DC 1.0
vd1 d1 0 DC 1.0
m1 d1 g 0 0 nch.1 w=1.6e-06 l=2e-07 nf=2.0 ad=1e-12 as=1e-12
vr1 r1 0 DC 1.0
mr1 r1 g 0 0 ref1 w=1.6e-06 l=2e-07 nf=2.0 ad=1e-12 as=1e-12
vd2 d2 0 DC 1.0
m2 d2 g 0 0 nch w=2e-06 l=2.1999999999999998e-07
vr2 r2 0 DC 1.0
mr2 r2 g 0 0 ref2 w=2e-06 l=2.1999999999999998e-07
vd3 d3 0 DC 1.0
m3 d3 g 0 0 nch w=5e-07 l=1e-06
vr3 r3 0 DC 1.0
mr3 r3 g 0 0 ref3 w=5e-07 l=1e-06
.options device temp=25.0 tnom=25.0
.tran 1e-10 1e-09
.print tran format=raw file=vamos_tran.raw i(vd1) i(vr1) i(vd2) i(vr2) i(vd3) i(vr3)
.end
