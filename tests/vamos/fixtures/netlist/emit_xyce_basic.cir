* vamos emitter golden: basic
* generated by vamos
.param vdd=1.8
.param wn=1e-06
.param gain={vdd/0.9}
.model nch nmos level=1 vto=0.5 kp=0.0001 lambda=0.02 gamma=0.5276252190748421 phi=0.5760365037084703 cj=0.00010185098195480395 fc=0.0
.model pch pmos level=1 vto=-0.5 kp=4e-05 lambda=0.02 gamma=0.5276252190748421 phi=0.5760365037084703 cj=0.00010185098195480395 fc=0.0
.model dd d level=1 is=1e-14 cjo=1e-12 fc=0.0 vj=0.8
.model qn npn level=1 is=1e-15 bf=100.0
.model jn njf level=1 vto=-2.0 beta=0.0001
.subckt inv a y vdd params: wp={2.5*wn} vamos_mfactor=1.0
mn y a ns 0 nch w={wn} l=1e-06 m={vamos_mfactor}
rsrc ns 0 10.0 m={vamos_mfactor}
mp y a vdd vdd pch w={wp} l=1e-06 m={vamos_mfactor}
cy y 0 1e-14 m={vamos_mfactor}
.ends inv
vsup vdd 0 DC {vdd}
vin in 0 PULSE(0.0 {vdd} 1e-09 1e-10 1e-10 4e-09 1e-08)
x1 in out vdd inv wp=3e-06
x2 out out2 vdd inv vamos_mfactor=2.0
rl out2 0 100000.0
r1 vdd rb 10000.0 tc1=0.001
d1 rb 0 dd
vsin s 0 SIN(0.5 0.2 100000000.0 1e-09 0.0 0.0)
rs s sb 1000.0
q1 sb sb 0 qn
vexp e 0 EXP(0.0 1.0 1e-09 1e-09 3e-09 1e-09)
re e 0 1000.0
vpwl p 0 PWL 5e-10 0.0 1.5000000000000002e-09 1.0 2.5e-09 0.5
rp p 0 1000.0
vj jd 0 DC 1.0
j1 jd 0 0 jn
e1 ea 0 out 0 {gain}
rea ea 0 1000.0
g1 0 ga out 0 0.001
rga ga 0 1000.0
vprobe vdd vp DC 0.0
rvp vp 0 10000.0
f1 0 fa vprobe 2.0
rfa fa 0 1000.0
h1 ha 0 vprobe 1000.0
rha ha 0 1000.0
bebeh bb 0 V={v(out)*0.5}
bgbeh 0 bc I={0.001*v(in)}
rbb bb 0 1000.0
rbc bc 0 1000.0
vl la 0 SIN(0.0 1.0 10000000.0 0.0 0.0 0.0)
l1 la lb 1e-06
l2 lc 0 4e-06
k1 l1 l2 0.5
rlb lb 0 10.0
rlc lc 0 100.0
i1 0 ib DC 1e-06
rib ib 0 1000.0
.options device temp=25.0 tnom=25.0
.tran 1e-11 2e-08
.print tran format=raw file=vamos_tran.raw v(out) v(out2) i(vsup) v(x1:ns) v(bc) v(fa) v(ha)
.end
