* rc fixture
V1 a 0 PULSE(0 1 0 1e-10 1e-10 1 2)
R1 a b 1000
C1 b 0 1e-12
.subckt hold x
R9 x n 1000
C9 n 0 1e-12
.ends
X1 b hold
.tran 1e-10 1e-9 0 2e-10
.print tran format=raw file=xtran.raw v(a) v(b) i(v1) v(x1:n)
.end
