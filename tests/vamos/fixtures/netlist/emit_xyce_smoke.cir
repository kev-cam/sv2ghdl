* vamos ams deck
* generated by vamos
.model nch nmos level=1 vto=0.5 kp=0.0001 lambda=0.02 gamma=0.5276252190748421 phi=0.5760365037084703
.model pch pmos level=1 vto=-0.5 kp=4e-05 lambda=0.02 gamma=0.5276252190748421 phi=0.5760365037084703
.subckt inv a y vdd params: vamos_mfactor=1.0
mn y a 0 0 nch w=1e-06 l=1e-06 m={vamos_mfactor}
mp y a vdd vdd pch w=2.5e-06 l=1e-06 m={vamos_mfactor}
cy y 0 1e-14 m={vamos_mfactor}
.ends inv
vd_n_u_a n_u_a_d 0 DC 0.0
ve_n_u_a n_u_a_e 0 DC 1.0
bg_n_u_a n_u_a_d n_u_a I={v(n_u_a_e)*(v(n_u_a_d)-v(n_u_a))/500.7}
rsh_n_u_a n_u_a 0 1000000000000.0
ia_n_u_y n_u_y 0 DC 0.0
rsh_n_u_y n_u_y 0 1000000000000.0
vs_n_vdd n_vdd 0 DC 1.8
xv_u n_u_a n_u_y n_vdd inv
.options device temp=25.0 tnom=25.0
.op
.end
