* rc ac fixture
V1 a 0 DC 0 AC 1
R1 a b 1000
C1 b 0 1e-12
.ac dec 1 1e6 1e9
.print ac format=raw file=xac.raw v(a) v(b)
.end
